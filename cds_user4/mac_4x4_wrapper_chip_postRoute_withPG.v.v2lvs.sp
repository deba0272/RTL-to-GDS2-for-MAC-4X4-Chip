$ Spice netlist generated by v2lvs
$ v2022.4_37.20    Fri Dec 2 17:42:37 PST 2022
.INCLUDE "/tools/sclpdk_new/SCLPDK_V3.0_KIT/scl180/iopad/cio150/6M1L/cdl/tsl18cio150.cdl"
.INCLUDE "/tools/sclpdk_new/SCLPDK_V3.0_KIT/scl180/stdcell/fs120/6M1L/cdl/scl18fs120_supply_pins.cdl"
*.BUSDELIMITER [

.SUBCKT dl04d1 I Z VSS VDD
.ENDS

.SUBCKT dl04d2 I Z VSS VDD
.ENDS

.SUBCKT buffd1 I Z VSS VDD
.ENDS

.SUBCKT buffd3 I Z VSS VDD
.ENDS

.SUBCKT dfnrq1 CP D Q VSS VDD
.ENDS

.SUBCKT oan211d1 A B C1 C2 ZN VSS VDD
.ENDS

.SUBCKT aoi211d1 A B C1 C2 ZN VSS VDD
.ENDS

.SUBCKT an02d1 A1 A2 Z VSS VDD
.ENDS

.SUBCKT nd02d1 A1 A2 ZN VSS VDD
.ENDS

.SUBCKT ad01d1 A B CI CO S VSS VDD
.ENDS

.SUBCKT nd12d1 A1 A2 ZN VSS VDD
.ENDS

.SUBCKT an03d1 A1 A2 A3 Z VSS VDD
.ENDS

.SUBCKT or02d1 A1 A2 Z VSS VDD
.ENDS

.SUBCKT ah01d1 A B CO S VSS VDD
.ENDS

.SUBCKT oai21d1 A B1 B2 ZN VSS VDD
.ENDS

.SUBCKT nr02d1 A1 A2 ZN VSS VDD
.ENDS

.SUBCKT oai22d1 A1 A2 B1 B2 ZN VSS VDD
.ENDS

.SUBCKT dfnrn1 CP D QN VSS VDD
.ENDS

.SUBCKT inv0d1 I ZN VSS VDD
.ENDS

.SUBCKT an12d1 A1 A2 Z VSS VDD
.ENDS

.SUBCKT aoi22d1 A1 A2 B1 B2 ZN VSS VDD
.ENDS

.SUBCKT xr03d1 A1 A2 A3 Z VSS VDD
.ENDS

.SUBCKT dfnrb1 CP D Q QN VSS VDD
.ENDS

.SUBCKT pc3c01 CCLK CP VSSO VSS VDDO VDD
.ENDS

.SUBCKT pc3d01 PAD CIN VSSO VSS VDDO VDD
.ENDS

.SUBCKT pc3o01 I PAD VSSO VSS VDDO VDD
.ENDS

.SUBCKT pvdi VSSO VSS VDDO VDD
.ENDS

.SUBCKT pv0i VSSO VSS VDDO VDD
.ENDS

.SUBCKT pvda VSSO VSS VDDO VDD
.ENDS

.SUBCKT pv0a VSSO VSS VDDO VDD
.ENDS

.SUBCKT mac_4x4 clk rst enable a[3] a[2] a[1] a[0] b[3] b[2] b[1] b[0]
+ mac_out[15] mac_out[14] mac_out[13] mac_out[12] mac_out[11] mac_out[10]
+ mac_out[9] mac_out[8] mac_out[7] mac_out[6] mac_out[5] mac_out[4] mac_out[3]
+ mac_out[2] mac_out[1] mac_out[0] VDD_CORE VSS_CORE
XFE_PHC132_n_15 dl04d1 $PINS I=n_15 Z=FE_PHN132_n_15 VSS=VSS_CORE VDD=VDD_CORE
XFE_PHC131_n_4 dl04d1 $PINS I=n_4 Z=FE_PHN131_n_4 VSS=VSS_CORE VDD=VDD_CORE
XFE_PHC130_n_10 dl04d1 $PINS I=n_10 Z=FE_PHN130_n_10 VSS=VSS_CORE VDD=VDD_CORE
XFE_PHC129_n_16 dl04d1 $PINS I=n_16 Z=FE_PHN129_n_16 VSS=VSS_CORE VDD=VDD_CORE
XFE_PHC128_n_9 dl04d1 $PINS I=n_9 Z=FE_PHN128_n_9 VSS=VSS_CORE VDD=VDD_CORE
XFE_PHC127_n_14 dl04d1 $PINS I=n_14 Z=FE_PHN127_n_14 VSS=VSS_CORE VDD=VDD_CORE
XFE_PHC126_n_7 dl04d1 $PINS I=n_7 Z=FE_PHN126_n_7 VSS=VSS_CORE VDD=VDD_CORE
XFE_PHC125_n_1 dl04d1 $PINS I=n_1 Z=FE_PHN125_n_1 VSS=VSS_CORE VDD=VDD_CORE
XFE_PHC124_n_12 dl04d1 $PINS I=n_12 Z=FE_PHN124_n_12 VSS=VSS_CORE VDD=VDD_CORE
XFE_PHC123_n_2 dl04d1 $PINS I=n_2 Z=FE_PHN123_n_2 VSS=VSS_CORE VDD=VDD_CORE
XFE_PHC122_n_8 dl04d1 $PINS I=n_8 Z=FE_PHN122_n_8 VSS=VSS_CORE VDD=VDD_CORE
XFE_PHC121_n_3 dl04d1 $PINS I=n_3 Z=FE_PHN121_n_3 VSS=VSS_CORE VDD=VDD_CORE
XFE_PHC120_n_89 dl04d1 $PINS I=n_89 Z=FE_PHN120_n_89 VSS=VSS_CORE VDD=VDD_CORE
XFE_PHC119_n_87 dl04d1 $PINS I=n_87 Z=FE_PHN119_n_87 VSS=VSS_CORE VDD=VDD_CORE
XFE_PHC118_n_94 dl04d1 $PINS I=n_94 Z=FE_PHN118_n_94 VSS=VSS_CORE VDD=VDD_CORE
XFE_PHC117_n_64 dl04d1 $PINS I=n_64 Z=FE_PHN117_n_64 VSS=VSS_CORE VDD=VDD_CORE
XFE_PHC116_n_93 dl04d1 $PINS I=n_93 Z=FE_PHN116_n_93 VSS=VSS_CORE VDD=VDD_CORE
XFE_PHC115_n_51 dl04d1 $PINS I=n_51 Z=FE_PHN115_n_51 VSS=VSS_CORE VDD=VDD_CORE
XFE_PHC114_n_11 dl04d1 $PINS I=n_11 Z=FE_PHN114_n_11 VSS=VSS_CORE VDD=VDD_CORE
XFE_PHC113_n_13 dl04d1 $PINS I=n_13 Z=FE_PHN113_n_13 VSS=VSS_CORE VDD=VDD_CORE
XFE_PHC112_enable_s1 dl04d1 $PINS I=enable_s1 Z=FE_PHN112_enable_s1
+ VSS=VSS_CORE VDD=VDD_CORE
XFE_PHC102_mac_out_pad_3 dl04d1 $PINS I=mac_out[3] Z=FE_PHN102_mac_out_pad_3
+ VSS=VSS_CORE VDD=VDD_CORE
XFE_PHC101_mac_out_pad_2 dl04d1 $PINS I=mac_out[2] Z=FE_PHN101_mac_out_pad_2
+ VSS=VSS_CORE VDD=VDD_CORE
XFE_PHC100_a_reg_3 dl04d1 $PINS I=a_reg[3] Z=FE_PHN100_a_reg_3 VSS=VSS_CORE
+ VDD=VDD_CORE
XFE_PHC99_a_reg_2 dl04d1 $PINS I=a_reg[2] Z=FE_PHN99_a_reg_2 VSS=VSS_CORE
+ VDD=VDD_CORE
XFE_PHC98_b_reg_3 dl04d1 $PINS I=b_reg[3] Z=FE_PHN98_b_reg_3 VSS=VSS_CORE
+ VDD=VDD_CORE
XFE_PHC97_b_reg_2 dl04d1 $PINS I=b_reg[2] Z=FE_PHN97_b_reg_2 VSS=VSS_CORE
+ VDD=VDD_CORE
XFE_PHC96_mult_reg_4 dl04d1 $PINS I=mult_reg[4] Z=FE_PHN96_mult_reg_4
+ VSS=VSS_CORE VDD=VDD_CORE
XFE_PHC95_mult_reg_3 dl04d1 $PINS I=mult_reg[3] Z=FE_PHN95_mult_reg_3
+ VSS=VSS_CORE VDD=VDD_CORE
XFE_PHC94_mult_reg_2 dl04d1 $PINS I=mult_reg[2] Z=FE_PHN94_mult_reg_2
+ VSS=VSS_CORE VDD=VDD_CORE
XFE_PHC93_n_2 dl04d1 $PINS I=FE_PHN123_n_2 Z=FE_PHN93_n_2 VSS=VSS_CORE
+ VDD=VDD_CORE
XFE_PHC92_n_3 dl04d1 $PINS I=FE_PHN121_n_3 Z=FE_PHN92_n_3 VSS=VSS_CORE
+ VDD=VDD_CORE
XFE_PHC91_n_12 dl04d1 $PINS I=FE_PHN124_n_12 Z=FE_PHN91_n_12 VSS=VSS_CORE
+ VDD=VDD_CORE
XFE_PHC90_n_5 dl04d1 $PINS I=n_5 Z=FE_PHN90_n_5 VSS=VSS_CORE VDD=VDD_CORE
XFE_PHC89_n_8 dl04d1 $PINS I=FE_PHN122_n_8 Z=FE_PHN89_n_8 VSS=VSS_CORE
+ VDD=VDD_CORE
XFE_PHC88_n_1 dl04d1 $PINS I=FE_PHN125_n_1 Z=FE_PHN88_n_1 VSS=VSS_CORE
+ VDD=VDD_CORE
XFE_PHC87_n_84 dl04d1 $PINS I=n_84 Z=FE_PHN87_n_84 VSS=VSS_CORE VDD=VDD_CORE
XFE_PHC86_n_87 dl04d1 $PINS I=FE_PHN119_n_87 Z=FE_PHN86_n_87 VSS=VSS_CORE
+ VDD=VDD_CORE
XFE_PHC85_n_6 dl04d1 $PINS I=n_6 Z=FE_PHN85_n_6 VSS=VSS_CORE VDD=VDD_CORE
XFE_PHC84_n_14 dl04d1 $PINS I=FE_PHN127_n_14 Z=FE_PHN84_n_14 VSS=VSS_CORE
+ VDD=VDD_CORE
XFE_PHC83_n_89 dl04d1 $PINS I=FE_PHN120_n_89 Z=FE_PHN83_n_89 VSS=VSS_CORE
+ VDD=VDD_CORE
XFE_PHC82_n_9 dl04d1 $PINS I=FE_PHN128_n_9 Z=FE_PHN82_n_9 VSS=VSS_CORE
+ VDD=VDD_CORE
XFE_PHC81_n_16 dl04d1 $PINS I=FE_PHN129_n_16 Z=FE_PHN81_n_16 VSS=VSS_CORE
+ VDD=VDD_CORE
XFE_PHC80_n_7 dl04d1 $PINS I=FE_PHN126_n_7 Z=FE_PHN80_n_7 VSS=VSS_CORE
+ VDD=VDD_CORE
XFE_PHC79_n_93 dl04d1 $PINS I=FE_PHN116_n_93 Z=FE_PHN79_n_93 VSS=VSS_CORE
+ VDD=VDD_CORE
XFE_PHC78_n_79 dl04d1 $PINS I=n_79 Z=FE_PHN78_n_79 VSS=VSS_CORE VDD=VDD_CORE
XFE_PHC77_n_94 dl04d1 $PINS I=FE_PHN118_n_94 Z=FE_PHN77_n_94 VSS=VSS_CORE
+ VDD=VDD_CORE
XFE_PHC76_n_15 dl04d1 $PINS I=FE_PHN132_n_15 Z=FE_PHN76_n_15 VSS=VSS_CORE
+ VDD=VDD_CORE
XFE_PHC75_n_4 dl04d1 $PINS I=FE_PHN131_n_4 Z=FE_PHN75_n_4 VSS=VSS_CORE
+ VDD=VDD_CORE
XFE_PHC74_n_10 dl04d1 $PINS I=FE_PHN130_n_10 Z=FE_PHN74_n_10 VSS=VSS_CORE
+ VDD=VDD_CORE
XFE_PHC73_a_pad_1 dl04d1 $PINS I=a[1] Z=FE_PHN73_a_pad_1 VSS=VSS_CORE
+ VDD=VDD_CORE
XFE_PHC72_enable_pad dl04d1 $PINS I=enable Z=FE_PHN72_enable_pad VSS=VSS_CORE
+ VDD=VDD_CORE
XFE_PHC71_b_pad_1 dl04d1 $PINS I=b[1] Z=FE_PHN71_b_pad_1 VSS=VSS_CORE
+ VDD=VDD_CORE
XFE_PHC70_b_pad_0 dl04d1 $PINS I=b[0] Z=FE_PHN70_b_pad_0 VSS=VSS_CORE
+ VDD=VDD_CORE
XFE_PHC69_a_pad_3 dl04d1 $PINS I=a[3] Z=FE_PHN69_a_pad_3 VSS=VSS_CORE
+ VDD=VDD_CORE
XFE_PHC68_a_pad_2 dl04d1 $PINS I=a[2] Z=FE_PHN68_a_pad_2 VSS=VSS_CORE
+ VDD=VDD_CORE
XFE_PHC67_a_pad_0 dl04d1 $PINS I=a[0] Z=FE_PHN67_a_pad_0 VSS=VSS_CORE
+ VDD=VDD_CORE
XFE_PHC66_b_pad_3 dl04d1 $PINS I=b[3] Z=FE_PHN66_b_pad_3 VSS=VSS_CORE
+ VDD=VDD_CORE
XFE_PHC65_b_pad_2 dl04d1 $PINS I=b[2] Z=FE_PHN65_b_pad_2 VSS=VSS_CORE
+ VDD=VDD_CORE
XFE_PHC64_enable_s1 dl04d1 $PINS I=FE_PHN112_enable_s1 Z=FE_PHN64_enable_s1
+ VSS=VSS_CORE VDD=VDD_CORE
XFE_PHC63_mult_reg_7 dl04d2 $PINS I=mult_reg[7] Z=FE_PHN63_mult_reg_7
+ VSS=VSS_CORE VDD=VDD_CORE
XFE_PHC62_n_0 dl04d1 $PINS I=n_0 Z=FE_PHN62_n_0 VSS=VSS_CORE VDD=VDD_CORE
XFE_PHC61_mult_reg_1 dl04d1 $PINS I=mult_reg[1] Z=FE_PHN61_mult_reg_1
+ VSS=VSS_CORE VDD=VDD_CORE
XFE_PHC60_mac_out_pad_0 dl04d1 $PINS I=FE_PHN20_mac_out_pad_0
+ Z=FE_PHN60_mac_out_pad_0 VSS=VSS_CORE VDD=VDD_CORE
XFE_PHC59_mac_out_pad_1 dl04d1 $PINS I=FE_PHN19_mac_out_pad_1
+ Z=FE_PHN59_mac_out_pad_1 VSS=VSS_CORE VDD=VDD_CORE
XFE_PHC58_enable_s2 dl04d1 $PINS I=enable_s2 Z=FE_PHN58_enable_s2 VSS=VSS_CORE
+ VDD=VDD_CORE
XFE_PHC57_mult_reg_0 dl04d1 $PINS I=mult_reg[0] Z=FE_PHN57_mult_reg_0
+ VSS=VSS_CORE VDD=VDD_CORE
XFE_PHC56_a_reg_1 dl04d1 $PINS I=a_reg[1] Z=FE_PHN56_a_reg_1 VSS=VSS_CORE
+ VDD=VDD_CORE
XFE_PHC55_a_reg_0 dl04d1 $PINS I=a_reg[0] Z=FE_PHN55_a_reg_0 VSS=VSS_CORE
+ VDD=VDD_CORE
XFE_PHC54_b_reg_1 dl04d1 $PINS I=b_reg[1] Z=FE_PHN54_b_reg_1 VSS=VSS_CORE
+ VDD=VDD_CORE
XFE_PHC53_b_reg_0 dl04d1 $PINS I=b_reg[0] Z=FE_PHN53_b_reg_0 VSS=VSS_CORE
+ VDD=VDD_CORE
XFE_PHC52_n_40 dl04d1 $PINS I=n_40 Z=FE_PHN52_n_40 VSS=VSS_CORE VDD=VDD_CORE
XFE_PHC51_n_42 dl04d1 $PINS I=n_42 Z=FE_PHN51_n_42 VSS=VSS_CORE VDD=VDD_CORE
XFE_PHC50_n_41 dl04d1 $PINS I=n_41 Z=FE_PHN50_n_41 VSS=VSS_CORE VDD=VDD_CORE
XFE_PHC49_n_37 dl04d1 $PINS I=n_37 Z=FE_PHN49_n_37 VSS=VSS_CORE VDD=VDD_CORE
XFE_PHC48_n_39 dl04d1 $PINS I=n_39 Z=FE_PHN48_n_39 VSS=VSS_CORE VDD=VDD_CORE
XFE_PHC47_n_43 dl04d1 $PINS I=n_43 Z=FE_PHN47_n_43 VSS=VSS_CORE VDD=VDD_CORE
XFE_PHC46_n_57 dl04d1 $PINS I=n_57 Z=FE_PHN46_n_57 VSS=VSS_CORE VDD=VDD_CORE
XFE_PHC45_n_38 dl04d1 $PINS I=n_38 Z=FE_PHN45_n_38 VSS=VSS_CORE VDD=VDD_CORE
XFE_PHC44_n_88 dl04d1 $PINS I=n_88 Z=FE_PHN44_n_88 VSS=VSS_CORE VDD=VDD_CORE
XFE_PHC43_n_23 dl04d1 $PINS I=n_23 Z=FE_PHN43_n_23 VSS=VSS_CORE VDD=VDD_CORE
XFE_PHC42_n_92 dl04d1 $PINS I=n_92 Z=FE_PHN42_n_92 VSS=VSS_CORE VDD=VDD_CORE
XFE_PHC41_n_85 dl04d1 $PINS I=n_85 Z=FE_PHN41_n_85 VSS=VSS_CORE VDD=VDD_CORE
XFE_PHC40_n_27 dl04d1 $PINS I=n_27 Z=FE_PHN40_n_27 VSS=VSS_CORE VDD=VDD_CORE
XFE_PHC39_n_29 dl04d1 $PINS I=n_29 Z=FE_PHN39_n_29 VSS=VSS_CORE VDD=VDD_CORE
XFE_PHC38_n_35 dl04d1 $PINS I=n_35 Z=FE_PHN38_n_35 VSS=VSS_CORE VDD=VDD_CORE
XFE_PHC37_n_36 dl04d1 $PINS I=n_36 Z=FE_PHN37_n_36 VSS=VSS_CORE VDD=VDD_CORE
XFE_PHC36_n_79 dl04d1 $PINS I=FE_PHN78_n_79 Z=FE_PHN36_n_79 VSS=VSS_CORE
+ VDD=VDD_CORE
XFE_PHC35_n_28 dl04d1 $PINS I=n_28 Z=FE_PHN35_n_28 VSS=VSS_CORE VDD=VDD_CORE
XFE_PHC34_n_22 dl04d1 $PINS I=n_22 Z=FE_PHN34_n_22 VSS=VSS_CORE VDD=VDD_CORE
XFE_PHC33_n_31 dl04d1 $PINS I=n_31 Z=FE_PHN33_n_31 VSS=VSS_CORE VDD=VDD_CORE
XFE_PHC32_n_25 dl04d1 $PINS I=n_25 Z=FE_PHN32_n_25 VSS=VSS_CORE VDD=VDD_CORE
XFE_PHC31_n_21 dl04d1 $PINS I=n_21 Z=FE_PHN31_n_21 VSS=VSS_CORE VDD=VDD_CORE
XFE_PHC30_n_94 dl04d1 $PINS I=FE_PHN77_n_94 Z=FE_PHN30_n_94 VSS=VSS_CORE
+ VDD=VDD_CORE
XFE_PHC29_n_24 dl04d1 $PINS I=n_24 Z=FE_PHN29_n_24 VSS=VSS_CORE VDD=VDD_CORE
XFE_PHC28_n_93 dl04d1 $PINS I=FE_PHN79_n_93 Z=FE_PHN28_n_93 VSS=VSS_CORE
+ VDD=VDD_CORE
XFE_PHC27_n_18 dl04d1 $PINS I=n_18 Z=FE_PHN27_n_18 VSS=VSS_CORE VDD=VDD_CORE
XFE_PHC26_n_30 dl04d1 $PINS I=n_30 Z=FE_PHN26_n_30 VSS=VSS_CORE VDD=VDD_CORE
XFE_PHC25_n_20 dl04d1 $PINS I=n_20 Z=FE_PHN25_n_20 VSS=VSS_CORE VDD=VDD_CORE
XFE_PHC24_n_19 dl04d1 $PINS I=n_19 Z=FE_PHN24_n_19 VSS=VSS_CORE VDD=VDD_CORE
XFE_PHC23_n_17 dl04d1 $PINS I=n_17 Z=FE_PHN23_n_17 VSS=VSS_CORE VDD=VDD_CORE
XFE_PHC22_mult_reg_0 dl04d1 $PINS I=FE_PHN57_mult_reg_0 Z=FE_PHN22_mult_reg_0
+ VSS=VSS_CORE VDD=VDD_CORE
XFE_PHC21_mult_reg_1 dl04d1 $PINS I=FE_PHN61_mult_reg_1 Z=FE_PHN21_mult_reg_1
+ VSS=VSS_CORE VDD=VDD_CORE
XFE_PHC20_mac_out_pad_0 dl04d1 $PINS I=mac_out[0] Z=FE_PHN20_mac_out_pad_0
+ VSS=VSS_CORE VDD=VDD_CORE
XFE_PHC19_mac_out_pad_1 dl04d1 $PINS I=mac_out[1] Z=FE_PHN19_mac_out_pad_1
+ VSS=VSS_CORE VDD=VDD_CORE
XFE_PHC18_enable_s2 dl04d1 $PINS I=FE_PHN58_enable_s2 Z=FE_PHN18_enable_s2
+ VSS=VSS_CORE VDD=VDD_CORE
XFE_PHC17_n_0 dl04d1 $PINS I=FE_PHN62_n_0 Z=FE_PHN17_n_0 VSS=VSS_CORE
+ VDD=VDD_CORE
XFE_PHC16_a_reg_0 dl04d1 $PINS I=FE_PHN55_a_reg_0 Z=FE_PHN16_a_reg_0
+ VSS=VSS_CORE VDD=VDD_CORE
XFE_PHC15_a_reg_1 dl04d1 $PINS I=FE_PHN56_a_reg_1 Z=FE_PHN15_a_reg_1
+ VSS=VSS_CORE VDD=VDD_CORE
XFE_PHC14_b_reg_0 dl04d1 $PINS I=FE_PHN53_b_reg_0 Z=FE_PHN14_b_reg_0
+ VSS=VSS_CORE VDD=VDD_CORE
XFE_PHC13_b_reg_1 dl04d1 $PINS I=FE_PHN54_b_reg_1 Z=FE_PHN13_b_reg_1
+ VSS=VSS_CORE VDD=VDD_CORE
XFE_OFC11_mac_out_pad_4 buffd3 $PINS I=FE_OFN11_mac_out_pad_4 Z=mac_out[4]
+ VSS=VSS_CORE VDD=VDD_CORE
Xmult_reg_reg[7] dfnrq1 $PINS CP=clk D=FE_PHN28_n_93 Q=mult_reg[7] VSS=VSS_CORE
+ VDD=VDD_CORE
Xmult_reg_reg[6] dfnrq1 $PINS CP=clk D=FE_PHN30_n_94 Q=mult_reg[6] VSS=VSS_CORE
+ VDD=VDD_CORE
Xg1149__2398 oan211d1 $PINS A=rst B=n_91 C1=n_90 C2=n_82 ZN=n_94 VSS=VSS_CORE
+ VDD=VDD_CORE
Xg1150__5107 aoi211d1 $PINS A=rst B=n_78 C1=n_90 C2=n_76 ZN=n_93 VSS=VSS_CORE
+ VDD=VDD_CORE
Xmult_reg_reg[5] dfnrq1 $PINS CP=clk D=FE_PHN42_n_92 Q=mult_reg[5] VSS=VSS_CORE
+ VDD=VDD_CORE
Xg1152__6260 an02d1 $PINS A1=n_34 A2=FE_PHN83_n_89 Z=n_92 VSS=VSS_CORE
+ VDD=VDD_CORE
Xg1153__4319 nd02d1 $PINS A1=n_90 A2=n_82 ZN=n_91 VSS=VSS_CORE VDD=VDD_CORE
Xg1154__8428 ad01d1 $PINS A=n_80 B=n_72 CI=n_86 CO=n_90 S=n_89 VSS=VSS_CORE
+ VDD=VDD_CORE
Xmult_reg_reg[4] dfnrq1 $PINS CP=clk D=FE_PHN44_n_88 Q=mult_reg[4] VSS=VSS_CORE
+ VDD=VDD_CORE
Xg1156__5526 an02d1 $PINS A1=n_34 A2=FE_PHN86_n_87 Z=n_88 VSS=VSS_CORE
+ VDD=VDD_CORE
Xg1157__6783 ad01d1 $PINS A=n_81 B=n_69 CI=n_83 CO=n_86 S=n_87 VSS=VSS_CORE
+ VDD=VDD_CORE
Xmult_reg_reg[3] dfnrq1 $PINS CP=clk D=FE_PHN41_n_85 Q=mult_reg[3] VSS=VSS_CORE
+ VDD=VDD_CORE
Xg1159__3680 an02d1 $PINS A1=n_34 A2=FE_PHN87_n_84 Z=n_85 VSS=VSS_CORE
+ VDD=VDD_CORE
Xg1160__1617 ad01d1 $PINS A=n_77 B=n_67 CI=n_70 CO=n_83 S=n_84 VSS=VSS_CORE
+ VDD=VDD_CORE
Xmult_reg_reg[2] dfnrq1 $PINS CP=clk D=FE_PHN36_n_79 Q=mult_reg[2] VSS=VSS_CORE
+ VDD=VDD_CORE
Xg1162__2802 ad01d1 $PINS A=n_65 B=n_53 CI=n_63 CO=n_80 S=n_81 VSS=VSS_CORE
+ VDD=VDD_CORE
Xg1163__1705 nd12d1 $PINS A1=n_78 A2=n_76 ZN=n_82 VSS=VSS_CORE VDD=VDD_CORE
Xg1164__5122 oan211d1 $PINS A=rst B=n_75 C1=n_73 C2=n_60 ZN=n_79 VSS=VSS_CORE
+ VDD=VDD_CORE
Xg1165__8246 an03d1 $PINS A1=n_74 A2=FE_PHN100_a_reg_3 A3=FE_PHN98_b_reg_3
+ Z=n_78 VSS=VSS_CORE VDD=VDD_CORE
Xg1166__7098 nd12d1 $PINS A1=n_71 A2=n_60 ZN=n_77 VSS=VSS_CORE VDD=VDD_CORE
Xg1167__6131 nd02d1 $PINS A1=n_73 A2=n_60 ZN=n_75 VSS=VSS_CORE VDD=VDD_CORE
Xg1168__1881 or02d1 $PINS A1=n_74 A2=FE_PHN98_b_reg_3 Z=n_76 VSS=VSS_CORE
+ VDD=VDD_CORE
Xg1169__5115 ad01d1 $PINS A=n_47 B=n_52 CI=n_61 CO=n_74 S=n_72 VSS=VSS_CORE
+ VDD=VDD_CORE
Xg1170__7482 ah01d1 $PINS A=n_68 B=n_50 CO=n_71 S=n_73 VSS=VSS_CORE
+ VDD=VDD_CORE
Xg1171__4733 ad01d1 $PINS A=n_46 B=n_54 CI=n_66 CO=n_69 S=n_70 VSS=VSS_CORE
+ VDD=VDD_CORE
Xmult_reg_reg[1] dfnrq1 $PINS CP=clk D=FE_PHN117_n_64 Q=mult_reg[1]
+ VSS=VSS_CORE VDD=VDD_CORE
Xg1173__6161 ah01d1 $PINS A=n_49 B=n_56 CO=n_67 S=n_68 VSS=VSS_CORE
+ VDD=VDD_CORE
Xg1174__9315 ah01d1 $PINS A=n_48 B=n_55 CO=n_65 S=n_66 VSS=VSS_CORE
+ VDD=VDD_CORE
Xg1175__9945 an03d1 $PINS A1=n_34 A2=n_60 A3=n_59 Z=n_64 VSS=VSS_CORE
+ VDD=VDD_CORE
Xmult_reg_reg[0] dfnrq1 $PINS CP=clk D=n_62 Q=mult_reg[0] VSS=VSS_CORE
+ VDD=VDD_CORE
Xg1177__2883 oai21d1 $PINS A=n_61 B1=n_33 B2=n_58 ZN=n_63 VSS=VSS_CORE
+ VDD=VDD_CORE
Xg1179__2346 nr02d1 $PINS A1=FE_PHN115_n_51 A2=rst ZN=n_62 VSS=VSS_CORE
+ VDD=VDD_CORE
Xg1180__1666 oai22d1 $PINS A1=FE_PHN15_a_reg_1 A2=FE_PHN14_b_reg_0
+ B1=FE_PHN16_a_reg_0 B2=FE_PHN13_b_reg_1 ZN=n_59 VSS=VSS_CORE VDD=VDD_CORE
Xg1181__7410 nd02d1 $PINS A1=n_33 A2=n_58 ZN=n_61 VSS=VSS_CORE VDD=VDD_CORE
Xg1182__6417 nd12d1 $PINS A1=FE_PHN115_n_51 A2=n_50 ZN=n_60 VSS=VSS_CORE
+ VDD=VDD_CORE
Xg1183__5477 nr02d1 $PINS A1=FE_PHN64_enable_s1 A2=rst ZN=n_57 VSS=VSS_CORE
+ VDD=VDD_CORE
Xg1184__2398 nd02d1 $PINS A1=n_45 A2=n_44 ZN=n_58 VSS=VSS_CORE VDD=VDD_CORE
Xg1185__5107 nr02d1 $PINS A1=FE_PHN16_a_reg_0 A2=FE_PHN97_b_reg_2 ZN=n_56
+ VSS=VSS_CORE VDD=VDD_CORE
Xg1186__6260 nd12d1 $PINS A1=FE_PHN14_b_reg_0 A2=FE_PHN100_a_reg_3 ZN=n_55
+ VSS=VSS_CORE VDD=VDD_CORE
Xg1187__4319 nd12d1 $PINS A1=FE_PHN16_a_reg_0 A2=FE_PHN98_b_reg_3 ZN=n_54
+ VSS=VSS_CORE VDD=VDD_CORE
Xg1188__8428 nd12d1 $PINS A1=FE_PHN15_a_reg_1 A2=FE_PHN98_b_reg_3 ZN=n_53
+ VSS=VSS_CORE VDD=VDD_CORE
Xg1189__5526 nd02d1 $PINS A1=FE_PHN98_b_reg_3 A2=n_44 ZN=n_52 VSS=VSS_CORE
+ VDD=VDD_CORE
Xg1191__6783 or02d1 $PINS A1=FE_PHN16_a_reg_0 A2=FE_PHN14_b_reg_0 Z=n_51
+ VSS=VSS_CORE VDD=VDD_CORE
Xg1192__3680 nr02d1 $PINS A1=FE_PHN99_a_reg_2 A2=FE_PHN14_b_reg_0 ZN=n_49
+ VSS=VSS_CORE VDD=VDD_CORE
Xg1193__1617 nr02d1 $PINS A1=FE_PHN15_a_reg_1 A2=FE_PHN13_b_reg_1 ZN=n_50
+ VSS=VSS_CORE VDD=VDD_CORE
Xg1194__2802 nr02d1 $PINS A1=FE_PHN99_a_reg_2 A2=FE_PHN13_b_reg_1 ZN=n_48
+ VSS=VSS_CORE VDD=VDD_CORE
Xg1195__1705 nd02d1 $PINS A1=n_45 A2=FE_PHN100_a_reg_3 ZN=n_47 VSS=VSS_CORE
+ VDD=VDD_CORE
Xg1196__5122 nr02d1 $PINS A1=FE_PHN15_a_reg_1 A2=FE_PHN97_b_reg_2 ZN=n_46
+ VSS=VSS_CORE VDD=VDD_CORE
Xenable_s1_reg dfnrn1 $PINS CP=clk D=FE_PHN52_n_40 QN=enable_s1 VSS=VSS_CORE
+ VDD=VDD_CORE
Xb_reg_reg[1] dfnrn1 $PINS CP=clk D=FE_PHN50_n_41 QN=b_reg[1] VSS=VSS_CORE
+ VDD=VDD_CORE
Xa_reg_reg[1] dfnrn1 $PINS CP=clk D=FE_PHN37_n_36 QN=a_reg[1] VSS=VSS_CORE
+ VDD=VDD_CORE
Xb_reg_reg[3] dfnrq1 $PINS CP=clk D=FE_PHN49_n_37 Q=b_reg[3] VSS=VSS_CORE
+ VDD=VDD_CORE
Xa_reg_reg[0] dfnrn1 $PINS CP=clk D=FE_PHN45_n_38 QN=a_reg[0] VSS=VSS_CORE
+ VDD=VDD_CORE
Xa_reg_reg[3] dfnrq1 $PINS CP=clk D=FE_PHN47_n_43 Q=a_reg[3] VSS=VSS_CORE
+ VDD=VDD_CORE
Xb_reg_reg[0] dfnrn1 $PINS CP=clk D=FE_PHN48_n_39 QN=b_reg[0] VSS=VSS_CORE
+ VDD=VDD_CORE
Xg1209__8246 an02d1 $PINS A1=n_34 A2=FE_PHN69_a_pad_3 Z=n_43 VSS=VSS_CORE
+ VDD=VDD_CORE
Xg1210__7098 an02d1 $PINS A1=n_34 A2=FE_PHN65_b_pad_2 Z=n_42 VSS=VSS_CORE
+ VDD=VDD_CORE
Xg1211__6131 an02d1 $PINS A1=n_34 A2=FE_PHN71_b_pad_1 Z=n_41 VSS=VSS_CORE
+ VDD=VDD_CORE
Xg1212__1881 an02d1 $PINS A1=n_34 A2=FE_PHN72_enable_pad Z=n_40 VSS=VSS_CORE
+ VDD=VDD_CORE
Xg1213__5115 an02d1 $PINS A1=n_34 A2=FE_PHN70_b_pad_0 Z=n_39 VSS=VSS_CORE
+ VDD=VDD_CORE
Xg1214__7482 an02d1 $PINS A1=n_34 A2=FE_PHN67_a_pad_0 Z=n_38 VSS=VSS_CORE
+ VDD=VDD_CORE
Xg1215__4733 an02d1 $PINS A1=n_34 A2=FE_PHN66_b_pad_3 Z=n_37 VSS=VSS_CORE
+ VDD=VDD_CORE
Xg1216__6161 an02d1 $PINS A1=n_34 A2=FE_PHN73_a_pad_1 Z=n_36 VSS=VSS_CORE
+ VDD=VDD_CORE
Xg1217__9315 an02d1 $PINS A1=n_34 A2=FE_PHN68_a_pad_2 Z=n_35 VSS=VSS_CORE
+ VDD=VDD_CORE
Xg1218 inv0d1 $PINS I=rst ZN=n_34 VSS=VSS_CORE VDD=VDD_CORE
Xg2__9945 an12d1 $PINS A1=FE_PHN13_b_reg_1 A2=FE_PHN100_a_reg_3 Z=n_33
+ VSS=VSS_CORE VDD=VDD_CORE
Xacc_reg_reg[7] dfnrq1 $PINS CP=clk D=FE_PHN33_n_31 Q=mac_out[7] VSS=VSS_CORE
+ VDD=VDD_CORE
Xacc_reg_reg[1] dfnrq1 $PINS CP=clk D=n_26 Q=mac_out[1] VSS=VSS_CORE
+ VDD=VDD_CORE
Xacc_reg_reg[5] dfnrq1 $PINS CP=clk D=FE_PHN23_n_17 Q=mac_out[5] VSS=VSS_CORE
+ VDD=VDD_CORE
Xacc_reg_reg[6] dfnrq1 $PINS CP=clk D=FE_PHN35_n_28 Q=mac_out[6] VSS=VSS_CORE
+ VDD=VDD_CORE
Xacc_reg_reg[0] dfnrq1 $PINS CP=clk D=n_32 Q=mac_out[0] VSS=VSS_CORE
+ VDD=VDD_CORE
Xacc_reg_reg[8] dfnrq1 $PINS CP=clk D=FE_PHN26_n_30 Q=mac_out[8] VSS=VSS_CORE
+ VDD=VDD_CORE
Xacc_reg_reg[9] dfnrq1 $PINS CP=clk D=FE_PHN39_n_29 Q=mac_out[9] VSS=VSS_CORE
+ VDD=VDD_CORE
Xacc_reg_reg[10] dfnrq1 $PINS CP=clk D=FE_PHN40_n_27 Q=mac_out[10] VSS=VSS_CORE
+ VDD=VDD_CORE
Xacc_reg_reg[14] dfnrq1 $PINS CP=clk D=FE_PHN29_n_24 Q=mac_out[14] VSS=VSS_CORE
+ VDD=VDD_CORE
Xacc_reg_reg[11] dfnrq1 $PINS CP=clk D=FE_PHN25_n_20 Q=mac_out[11] VSS=VSS_CORE
+ VDD=VDD_CORE
Xacc_reg_reg[12] dfnrq1 $PINS CP=clk D=FE_PHN43_n_23 Q=mac_out[12] VSS=VSS_CORE
+ VDD=VDD_CORE
Xacc_reg_reg[13] dfnrq1 $PINS CP=clk D=FE_PHN31_n_21 Q=mac_out[13] VSS=VSS_CORE
+ VDD=VDD_CORE
Xacc_reg_reg[2] dfnrq1 $PINS CP=clk D=FE_PHN32_n_25 Q=mac_out[2] VSS=VSS_CORE
+ VDD=VDD_CORE
Xacc_reg_reg[3] dfnrq1 $PINS CP=clk D=FE_PHN34_n_22 Q=mac_out[3] VSS=VSS_CORE
+ VDD=VDD_CORE
Xacc_reg_reg[15] dfnrq1 $PINS CP=clk D=FE_PHN24_n_19 Q=mac_out[15] VSS=VSS_CORE
+ VDD=VDD_CORE
Xacc_reg_reg[4] dfnrq1 $PINS CP=clk D=FE_PHN27_n_18 Q=FE_OFN11_mac_out_pad_4
+ VSS=VSS_CORE VDD=VDD_CORE
Xg662__2883 nr02d1 $PINS A1=FE_PHN113_n_13 A2=rst ZN=n_32 VSS=VSS_CORE
+ VDD=VDD_CORE
Xg663__2346 nr02d1 $PINS A1=FE_PHN76_n_15 A2=rst ZN=n_31 VSS=VSS_CORE
+ VDD=VDD_CORE
Xg664__1666 nr02d1 $PINS A1=FE_PHN84_n_14 A2=rst ZN=n_30 VSS=VSS_CORE
+ VDD=VDD_CORE
Xg665__7410 nr02d1 $PINS A1=FE_PHN81_n_16 A2=rst ZN=n_29 VSS=VSS_CORE
+ VDD=VDD_CORE
Xg666__6417 nr02d1 $PINS A1=FE_PHN91_n_12 A2=rst ZN=n_28 VSS=VSS_CORE
+ VDD=VDD_CORE
Xg667__5477 nr02d1 $PINS A1=FE_PHN74_n_10 A2=rst ZN=n_27 VSS=VSS_CORE
+ VDD=VDD_CORE
Xg668__2398 nr02d1 $PINS A1=FE_PHN114_n_11 A2=rst ZN=n_26 VSS=VSS_CORE
+ VDD=VDD_CORE
Xg669__5107 nr02d1 $PINS A1=FE_PHN90_n_5 A2=rst ZN=n_25 VSS=VSS_CORE
+ VDD=VDD_CORE
Xg670__6260 nr02d1 $PINS A1=FE_PHN89_n_8 A2=rst ZN=n_24 VSS=VSS_CORE
+ VDD=VDD_CORE
Xg671__4319 nr02d1 $PINS A1=FE_PHN75_n_4 A2=rst ZN=n_23 VSS=VSS_CORE
+ VDD=VDD_CORE
Xg672__8428 nr02d1 $PINS A1=FE_PHN85_n_6 A2=rst ZN=n_22 VSS=VSS_CORE
+ VDD=VDD_CORE
Xg673__5526 nr02d1 $PINS A1=FE_PHN80_n_7 A2=rst ZN=n_21 VSS=VSS_CORE
+ VDD=VDD_CORE
Xg674__6783 nr02d1 $PINS A1=FE_PHN82_n_9 A2=rst ZN=n_20 VSS=VSS_CORE
+ VDD=VDD_CORE
Xg675__3680 nr02d1 $PINS A1=FE_PHN92_n_3 A2=rst ZN=n_19 VSS=VSS_CORE
+ VDD=VDD_CORE
Xg676__1617 nr02d1 $PINS A1=FE_PHN93_n_2 A2=rst ZN=n_18 VSS=VSS_CORE
+ VDD=VDD_CORE
Xg677__2802 nr02d1 $PINS A1=FE_PHN88_n_1 A2=rst ZN=n_17 VSS=VSS_CORE
+ VDD=VDD_CORE
Xg678__1705 aoi22d1 $PINS A1=mac_out[9] A2=FE_PHN17_n_0 B1=n_110
+ B2=FE_PHN18_enable_s2 ZN=n_16 VSS=VSS_CORE VDD=VDD_CORE
Xg679__5122 aoi22d1 $PINS A1=mac_out[7] A2=FE_PHN17_n_0 B1=n_112
+ B2=FE_PHN18_enable_s2 ZN=n_15 VSS=VSS_CORE VDD=VDD_CORE
Xg680__8246 aoi22d1 $PINS A1=mac_out[8] A2=FE_PHN17_n_0 B1=n_111
+ B2=FE_PHN18_enable_s2 ZN=n_14 VSS=VSS_CORE VDD=VDD_CORE
Xg681__7098 aoi22d1 $PINS A1=FE_PHN60_mac_out_pad_0 A2=FE_PHN17_n_0 B1=n_119
+ B2=FE_PHN18_enable_s2 ZN=n_13 VSS=VSS_CORE VDD=VDD_CORE
Xg682__6131 aoi22d1 $PINS A1=mac_out[6] A2=FE_PHN17_n_0 B1=n_113
+ B2=FE_PHN18_enable_s2 ZN=n_12 VSS=VSS_CORE VDD=VDD_CORE
Xg683__1881 aoi22d1 $PINS A1=FE_PHN59_mac_out_pad_1 A2=FE_PHN17_n_0 B1=n_118
+ B2=FE_PHN18_enable_s2 ZN=n_11 VSS=VSS_CORE VDD=VDD_CORE
Xg684__5115 aoi22d1 $PINS A1=mac_out[10] A2=FE_PHN17_n_0 B1=n_109
+ B2=FE_PHN18_enable_s2 ZN=n_10 VSS=VSS_CORE VDD=VDD_CORE
Xg685__7482 aoi22d1 $PINS A1=mac_out[11] A2=FE_PHN17_n_0 B1=n_108
+ B2=FE_PHN18_enable_s2 ZN=n_9 VSS=VSS_CORE VDD=VDD_CORE
Xg686__4733 aoi22d1 $PINS A1=mac_out[14] A2=FE_PHN17_n_0 B1=n_105
+ B2=FE_PHN18_enable_s2 ZN=n_8 VSS=VSS_CORE VDD=VDD_CORE
Xg687__6161 aoi22d1 $PINS A1=mac_out[13] A2=FE_PHN17_n_0 B1=n_106
+ B2=FE_PHN18_enable_s2 ZN=n_7 VSS=VSS_CORE VDD=VDD_CORE
Xg688__9315 aoi22d1 $PINS A1=FE_PHN102_mac_out_pad_3 A2=FE_PHN17_n_0 B1=n_116
+ B2=FE_PHN18_enable_s2 ZN=n_6 VSS=VSS_CORE VDD=VDD_CORE
Xg689__9945 aoi22d1 $PINS A1=FE_PHN101_mac_out_pad_2 A2=FE_PHN17_n_0 B1=n_117
+ B2=FE_PHN18_enable_s2 ZN=n_5 VSS=VSS_CORE VDD=VDD_CORE
Xg690__2883 aoi22d1 $PINS A1=mac_out[12] A2=FE_PHN17_n_0 B1=n_107
+ B2=FE_PHN18_enable_s2 ZN=n_4 VSS=VSS_CORE VDD=VDD_CORE
Xg691__2346 aoi22d1 $PINS A1=mac_out[15] A2=FE_PHN17_n_0 B1=n_122
+ B2=FE_PHN18_enable_s2 ZN=n_3 VSS=VSS_CORE VDD=VDD_CORE
Xg692__1666 aoi22d1 $PINS A1=mac_out[4] A2=FE_PHN17_n_0 B1=n_115
+ B2=FE_PHN18_enable_s2 ZN=n_2 VSS=VSS_CORE VDD=VDD_CORE
Xg693__7410 aoi22d1 $PINS A1=mac_out[5] A2=FE_PHN17_n_0 B1=n_114
+ B2=FE_PHN18_enable_s2 ZN=n_1 VSS=VSS_CORE VDD=VDD_CORE
Xadd_89_32_g369__5477 ad01d1 $PINS A=mac_out[14] B=FE_PHN63_mult_reg_7
+ CI=add_89_32_n_28 CO=add_89_32_n_31 S=n_105 VSS=VSS_CORE VDD=VDD_CORE
Xadd_89_32_g370__2398 ad01d1 $PINS A=mac_out[13] B=FE_PHN63_mult_reg_7
+ CI=add_89_32_n_26 CO=add_89_32_n_28 S=n_106 VSS=VSS_CORE VDD=VDD_CORE
Xadd_89_32_g371__5107 ad01d1 $PINS A=mac_out[12] B=FE_PHN63_mult_reg_7
+ CI=add_89_32_n_24 CO=add_89_32_n_26 S=n_107 VSS=VSS_CORE VDD=VDD_CORE
Xadd_89_32_g372__6260 ad01d1 $PINS A=mac_out[11] B=FE_PHN63_mult_reg_7
+ CI=add_89_32_n_22 CO=add_89_32_n_24 S=n_108 VSS=VSS_CORE VDD=VDD_CORE
Xadd_89_32_g373__4319 ad01d1 $PINS A=mac_out[10] B=FE_PHN63_mult_reg_7
+ CI=add_89_32_n_20 CO=add_89_32_n_22 S=n_109 VSS=VSS_CORE VDD=VDD_CORE
Xadd_89_32_g374__8428 ad01d1 $PINS A=mac_out[9] B=FE_PHN63_mult_reg_7
+ CI=add_89_32_n_18 CO=add_89_32_n_20 S=n_110 VSS=VSS_CORE VDD=VDD_CORE
Xadd_89_32_g375__5526 ad01d1 $PINS A=mac_out[8] B=FE_PHN63_mult_reg_7
+ CI=add_89_32_n_16 CO=add_89_32_n_18 S=n_111 VSS=VSS_CORE VDD=VDD_CORE
Xadd_89_32_g376__6783 ad01d1 $PINS A=mac_out[7] B=FE_PHN63_mult_reg_7
+ CI=add_89_32_n_14 CO=add_89_32_n_16 S=n_112 VSS=VSS_CORE VDD=VDD_CORE
Xadd_89_32_g377__3680 ad01d1 $PINS A=mac_out[6] B=mult_reg[6] CI=add_89_32_n_12
+ CO=add_89_32_n_14 S=n_113 VSS=VSS_CORE VDD=VDD_CORE
Xadd_89_32_g378__1617 ad01d1 $PINS A=mac_out[5] B=mult_reg[5] CI=add_89_32_n_10
+ CO=add_89_32_n_12 S=n_114 VSS=VSS_CORE VDD=VDD_CORE
Xadd_89_32_g379__2802 ad01d1 $PINS A=mac_out[4] B=FE_PHN96_mult_reg_4
+ CI=add_89_32_n_8 CO=add_89_32_n_10 S=n_115 VSS=VSS_CORE VDD=VDD_CORE
Xadd_89_32_g380__1705 ad01d1 $PINS A=FE_PHN102_mac_out_pad_3
+ B=FE_PHN95_mult_reg_3 CI=add_89_32_n_6 CO=add_89_32_n_8 S=n_116 VSS=VSS_CORE
+ VDD=VDD_CORE
Xadd_89_32_g381__5122 ad01d1 $PINS A=FE_PHN101_mac_out_pad_2
+ B=FE_PHN94_mult_reg_2 CI=add_89_32_n_4 CO=add_89_32_n_6 S=n_117 VSS=VSS_CORE
+ VDD=VDD_CORE
Xadd_89_32_g382__8246 ad01d1 $PINS A=FE_PHN59_mac_out_pad_1
+ B=FE_PHN21_mult_reg_1 CI=add_89_32_n_2 CO=add_89_32_n_4 S=n_118 VSS=VSS_CORE
+ VDD=VDD_CORE
Xadd_89_32_g383__7098 ah01d1 $PINS A=FE_PHN60_mac_out_pad_0
+ B=FE_PHN22_mult_reg_0 CO=add_89_32_n_2 S=n_119 VSS=VSS_CORE VDD=VDD_CORE
Xg2 xr03d1 $PINS A1=add_89_32_n_31 A2=mac_out[15] A3=FE_PHN63_mult_reg_7
+ Z=n_122 VSS=VSS_CORE VDD=VDD_CORE
Xb_reg_reg[2] dfnrb1 $PINS CP=clk D=FE_PHN51_n_42 Q=n_45 QN=b_reg[2]
+ VSS=VSS_CORE VDD=VDD_CORE
Xa_reg_reg[2] dfnrb1 $PINS CP=clk D=FE_PHN38_n_35 Q=n_44 QN=a_reg[2]
+ VSS=VSS_CORE VDD=VDD_CORE
Xenable_s2_reg dfnrb1 $PINS CP=clk D=FE_PHN46_n_57 Q=enable_s2 QN=n_0
+ VSS=VSS_CORE VDD=VDD_CORE
.ENDS

.SUBCKT mac_4x4_wrapper_chip clk rst enable a[3] a[2] a[1] a[0] b[3] b[2] b[1]
+ b[0] mac_out[15] mac_out[14] mac_out[13] mac_out[12] mac_out[11] mac_out[10]
+ mac_out[9] mac_out[8] mac_out[7] mac_out[6] mac_out[5] mac_out[4] mac_out[3]
+ mac_out[2] mac_out[1] mac_out[0]
XFE_PHC111_b_pad_3 dl04d1 $PINS I=b_pad[3] Z=FE_PHN111_b_pad_3 VSS=VSS_CORE
+ VDD=VDD_CORE
XFE_PHC110_b_pad_0 dl04d1 $PINS I=b_pad[0] Z=FE_PHN110_b_pad_0 VSS=VSS_CORE
+ VDD=VDD_CORE
XFE_PHC109_b_pad_2 dl04d1 $PINS I=b_pad[2] Z=FE_PHN109_b_pad_2 VSS=VSS_CORE
+ VDD=VDD_CORE
XFE_PHC108_enable_pad dl04d1 $PINS I=enable_pad Z=FE_PHN108_enable_pad
+ VSS=VSS_CORE VDD=VDD_CORE
XFE_PHC107_b_pad_1 dl04d1 $PINS I=b_pad[1] Z=FE_PHN107_b_pad_1 VSS=VSS_CORE
+ VDD=VDD_CORE
XFE_PHC106_a_pad_0 dl04d1 $PINS I=a_pad[0] Z=FE_PHN106_a_pad_0 VSS=VSS_CORE
+ VDD=VDD_CORE
XFE_PHC105_a_pad_3 dl04d1 $PINS I=a_pad[3] Z=FE_PHN105_a_pad_3 VSS=VSS_CORE
+ VDD=VDD_CORE
XFE_PHC104_a_pad_1 dl04d1 $PINS I=a_pad[1] Z=FE_PHN104_a_pad_1 VSS=VSS_CORE
+ VDD=VDD_CORE
XFE_PHC103_a_pad_2 dl04d1 $PINS I=a_pad[2] Z=FE_PHN103_a_pad_2 VSS=VSS_CORE
+ VDD=VDD_CORE
XFE_PHC12_rst_pad dl04d2 $PINS I=rst_pad Z=FE_PHN12_rst_pad VSS=VSS_CORE
+ VDD=VDD_CORE
XFE_OFC13_mac_out_pad_15 buffd1 $PINS I=mac_out_pad[15]
+ Z=FE_OFN13_mac_out_pad_15 VSS=VSS_CORE VDD=VDD_CORE
XFE_OFC12_mac_out_pad_14 buffd1 $PINS I=mac_out_pad[14]
+ Z=FE_OFN12_mac_out_pad_14 VSS=VSS_CORE VDD=VDD_CORE
XFE_OFC10_mac_out_pad_5 buffd1 $PINS I=mac_out_pad[5] Z=FE_OFN10_mac_out_pad_5
+ VSS=VSS_CORE VDD=VDD_CORE
XFE_OFC9_mac_out_pad_6 buffd1 $PINS I=mac_out_pad[6] Z=FE_OFN9_mac_out_pad_6
+ VSS=VSS_CORE VDD=VDD_CORE
XFE_OFC8_mac_out_pad_7 buffd1 $PINS I=mac_out_pad[7] Z=FE_OFN8_mac_out_pad_7
+ VSS=VSS_CORE VDD=VDD_CORE
XFE_OFC7_mac_out_pad_8 buffd1 $PINS I=mac_out_pad[8] Z=FE_OFN7_mac_out_pad_8
+ VSS=VSS_CORE VDD=VDD_CORE
XFE_OFC6_mac_out_pad_9 buffd1 $PINS I=mac_out_pad[9] Z=FE_OFN6_mac_out_pad_9
+ VSS=VSS_CORE VDD=VDD_CORE
XFE_OFC5_mac_out_pad_10 buffd1 $PINS I=mac_out_pad[10] Z=FE_OFN5_mac_out_pad_10
+ VSS=VSS_CORE VDD=VDD_CORE
XFE_OFC4_mac_out_pad_11 buffd3 $PINS I=mac_out_pad[11] Z=FE_OFN4_mac_out_pad_11
+ VSS=VSS_CORE VDD=VDD_CORE
XFE_OFC3_mac_out_pad_12 buffd1 $PINS I=mac_out_pad[12] Z=FE_OFN3_mac_out_pad_12
+ VSS=VSS_CORE VDD=VDD_CORE
XFE_OFC2_mac_out_pad_13 buffd1 $PINS I=mac_out_pad[13] Z=FE_OFN2_mac_out_pad_13
+ VSS=VSS_CORE VDD=VDD_CORE
Xdut mac_4x4 $PINS clk=clk_buf rst=FE_PHN12_rst_pad enable=FE_PHN108_enable_pad
+ a[3]=FE_PHN105_a_pad_3 a[2]=FE_PHN103_a_pad_2 a[1]=FE_PHN104_a_pad_1
+ a[0]=FE_PHN106_a_pad_0 b[3]=FE_PHN111_b_pad_3 b[2]=FE_PHN109_b_pad_2
+ b[1]=FE_PHN107_b_pad_1 b[0]=FE_PHN110_b_pad_0 mac_out[15]=mac_out_pad[15]
+ mac_out[14]=mac_out_pad[14] mac_out[13]=mac_out_pad[13]
+ mac_out[12]=mac_out_pad[12] mac_out[11]=mac_out_pad[11]
+ mac_out[10]=mac_out_pad[10] mac_out[9]=mac_out_pad[9] mac_out[8]=mac_out_pad[8]
+ mac_out[7]=mac_out_pad[7] mac_out[6]=mac_out_pad[6] mac_out[5]=mac_out_pad[5]
+ mac_out[4]=mac_out_pad[4] mac_out[3]=mac_out_pad[3] mac_out[2]=mac_out_pad[2]
+ mac_out[1]=mac_out_pad[1] mac_out[0]=mac_out_pad[0] VDD_CORE=VDD_CORE
+ VSS_CORE=VSS_CORE
Xpc3c01_clk_buf pc3c01 $PINS CCLK=clk_pad CP=clk_buf VSSO=VSSO_CORE
+ VSS=VSS_CORE VDDO=VDDO_CORE VDD=VDD_CORE
Xpc3d01_a0 pc3d01 $PINS PAD=a[0] CIN=a_pad[0] VSSO=VSSO_CORE VSS=VSS_CORE
+ VDDO=VDDO_CORE VDD=VDD_CORE
Xpc3d01_a1 pc3d01 $PINS PAD=a[1] CIN=a_pad[1] VSSO=VSSO_CORE VSS=VSS_CORE
+ VDDO=VDDO_CORE VDD=VDD_CORE
Xpc3d01_a2 pc3d01 $PINS PAD=a[2] CIN=a_pad[2] VSSO=VSSO_CORE VSS=VSS_CORE
+ VDDO=VDDO_CORE VDD=VDD_CORE
Xpc3d01_a3 pc3d01 $PINS PAD=a[3] CIN=a_pad[3] VSSO=VSSO_CORE VSS=VSS_CORE
+ VDDO=VDDO_CORE VDD=VDD_CORE
Xpc3d01_b0 pc3d01 $PINS PAD=b[0] CIN=b_pad[0] VSSO=VSSO_CORE VSS=VSS_CORE
+ VDDO=VDDO_CORE VDD=VDD_CORE
Xpc3d01_b1 pc3d01 $PINS PAD=b[1] CIN=b_pad[1] VSSO=VSSO_CORE VSS=VSS_CORE
+ VDDO=VDDO_CORE VDD=VDD_CORE
Xpc3d01_b2 pc3d01 $PINS PAD=b[2] CIN=b_pad[2] VSSO=VSSO_CORE VSS=VSS_CORE
+ VDDO=VDDO_CORE VDD=VDD_CORE
Xpc3d01_b3 pc3d01 $PINS PAD=b[3] CIN=b_pad[3] VSSO=VSSO_CORE VSS=VSS_CORE
+ VDDO=VDDO_CORE VDD=VDD_CORE
Xpc3d01_clk pc3d01 $PINS PAD=clk CIN=clk_pad VSSO=VSSO_CORE VSS=VSS_CORE
+ VDDO=VDDO_CORE VDD=VDD_CORE
Xpc3d01_enable pc3d01 $PINS PAD=enable CIN=enable_pad VSSO=VSSO_CORE
+ VSS=VSS_CORE VDDO=VDDO_CORE VDD=VDD_CORE
Xpc3d01_rst pc3d01 $PINS PAD=rst CIN=rst_pad VSSO=VSSO_CORE VSS=VSS_CORE
+ VDDO=VDDO_CORE VDD=VDD_CORE
Xpc3o01_mac_out0 pc3o01 $PINS I=mac_out_pad[0] PAD=mac_out[0] VSSO=VSSO_CORE
+ VSS=VSS_CORE VDDO=VDDO_CORE VDD=VDD_CORE
Xpc3o01_mac_out1 pc3o01 $PINS I=mac_out_pad[1] PAD=mac_out[1] VSSO=VSSO_CORE
+ VSS=VSS_CORE VDDO=VDDO_CORE VDD=VDD_CORE
Xpc3o01_mac_out2 pc3o01 $PINS I=mac_out_pad[2] PAD=mac_out[2] VSSO=VSSO_CORE
+ VSS=VSS_CORE VDDO=VDDO_CORE VDD=VDD_CORE
Xpc3o01_mac_out3 pc3o01 $PINS I=mac_out_pad[3] PAD=mac_out[3] VSSO=VSSO_CORE
+ VSS=VSS_CORE VDDO=VDDO_CORE VDD=VDD_CORE
Xpc3o01_mac_out4 pc3o01 $PINS I=mac_out_pad[4] PAD=mac_out[4] VSSO=VSSO_CORE
+ VSS=VSS_CORE VDDO=VDDO_CORE VDD=VDD_CORE
Xpc3o01_mac_out5 pc3o01 $PINS I=FE_OFN10_mac_out_pad_5 PAD=mac_out[5]
+ VSSO=VSSO_CORE VSS=VSS_CORE VDDO=VDDO_CORE VDD=VDD_CORE
Xpc3o01_mac_out6 pc3o01 $PINS I=FE_OFN9_mac_out_pad_6 PAD=mac_out[6]
+ VSSO=VSSO_CORE VSS=VSS_CORE VDDO=VDDO_CORE VDD=VDD_CORE
Xpc3o01_mac_out7 pc3o01 $PINS I=FE_OFN8_mac_out_pad_7 PAD=mac_out[7]
+ VSSO=VSSO_CORE VSS=VSS_CORE VDDO=VDDO_CORE VDD=VDD_CORE
Xpc3o01_mac_out8 pc3o01 $PINS I=FE_OFN7_mac_out_pad_8 PAD=mac_out[8]
+ VSSO=VSSO_CORE VSS=VSS_CORE VDDO=VDDO_CORE VDD=VDD_CORE
Xpc3o01_mac_out9 pc3o01 $PINS I=FE_OFN6_mac_out_pad_9 PAD=mac_out[9]
+ VSSO=VSSO_CORE VSS=VSS_CORE VDDO=VDDO_CORE VDD=VDD_CORE
Xpc3o01_mac_out10 pc3o01 $PINS I=FE_OFN5_mac_out_pad_10 PAD=mac_out[10]
+ VSSO=VSSO_CORE VSS=VSS_CORE VDDO=VDDO_CORE VDD=VDD_CORE
Xpc3o01_mac_out11 pc3o01 $PINS I=FE_OFN4_mac_out_pad_11 PAD=mac_out[11]
+ VSSO=VSSO_CORE VSS=VSS_CORE VDDO=VDDO_CORE VDD=VDD_CORE
Xpc3o01_mac_out12 pc3o01 $PINS I=FE_OFN3_mac_out_pad_12 PAD=mac_out[12]
+ VSSO=VSSO_CORE VSS=VSS_CORE VDDO=VDDO_CORE VDD=VDD_CORE
Xpc3o01_mac_out13 pc3o01 $PINS I=FE_OFN2_mac_out_pad_13 PAD=mac_out[13]
+ VSSO=VSSO_CORE VSS=VSS_CORE VDDO=VDDO_CORE VDD=VDD_CORE
Xpc3o01_mac_out14 pc3o01 $PINS I=FE_OFN12_mac_out_pad_14 PAD=mac_out[14]
+ VSSO=VSSO_CORE VSS=VSS_CORE VDDO=VDDO_CORE VDD=VDD_CORE
Xpc3o01_mac_out15 pc3o01 $PINS I=FE_OFN13_mac_out_pad_15 PAD=mac_out[15]
+ VSSO=VSSO_CORE VSS=VSS_CORE VDDO=VDDO_CORE VDD=VDD_CORE
Xpc3o01_dummy1 pc3o01 $PINS VSSO=VSSO_CORE VSS=VSS_CORE VDDO=VDDO_CORE
+ VDD=VDD_CORE
Xpc3o01_dummy2 pc3o01 $PINS VSSO=VSSO_CORE VSS=VSS_CORE VDDO=VDDO_CORE
+ VDD=VDD_CORE
Xpc3o01_dummy3 pc3o01 $PINS VSSO=VSSO_CORE VSS=VSS_CORE VDDO=VDDO_CORE
+ VDD=VDD_CORE
Xpc3o01_dummy4 pc3o01 $PINS VSSO=VSSO_CORE VSS=VSS_CORE VDDO=VDDO_CORE
+ VDD=VDD_CORE
Xpvdi_VDD_0 pvdi $PINS VSSO=VSSO_CORE VSS=VSS_CORE VDDO=VDDO_CORE VDD=VDD_CORE
Xpv0i_VSS_0 pv0i $PINS VSSO=VSSO_CORE VSS=VSS_CORE VDDO=VDDO_CORE VDD=VDD_CORE
Xpvda_VDDO_0 pvda $PINS VSSO=VSSO_CORE VSS=VSS_CORE VDDO=VDDO_CORE VDD=VDD_CORE
Xpv0a_VSSO_0 pv0a $PINS VSSO=VSSO_CORE VSS=VSS_CORE VDDO=VDDO_CORE VDD=VDD_CORE
Xpvdi_VDD_1 pvdi $PINS VSSO=VSSO_CORE VSS=VSS_CORE VDDO=VDDO_CORE VDD=VDD_CORE
Xpv0i_VSS_1 pv0i $PINS VSSO=VSSO_CORE VSS=VSS_CORE VDDO=VDDO_CORE VDD=VDD_CORE
Xpvda_VDDO_1 pvda $PINS VSSO=VSSO_CORE VSS=VSS_CORE VDDO=VDDO_CORE VDD=VDD_CORE
Xpv0a_VSSO_1 pv0a $PINS VSSO=VSSO_CORE VSS=VSS_CORE VDDO=VDDO_CORE VDD=VDD_CORE
Xpvdi_VDD_2 pvdi $PINS VSSO=VSSO_CORE VSS=VSS_CORE VDDO=VDDO_CORE VDD=VDD_CORE
Xpv0i_VSS_2 pv0i $PINS VSSO=VSSO_CORE VSS=VSS_CORE VDDO=VDDO_CORE VDD=VDD_CORE
Xpvda_VDDO_2 pvda $PINS VSSO=VSSO_CORE VSS=VSS_CORE VDDO=VDDO_CORE VDD=VDD_CORE
Xpv0a_VSSO_2 pv0a $PINS VSSO=VSSO_CORE VSS=VSS_CORE VDDO=VDDO_CORE VDD=VDD_CORE
Xpvdi_VDD_3 pvdi $PINS VSSO=VSSO_CORE VSS=VSS_CORE VDDO=VDDO_CORE VDD=VDD_CORE
Xpv0i_VSS_3 pv0i $PINS VSSO=VSSO_CORE VSS=VSS_CORE VDDO=VDDO_CORE VDD=VDD_CORE
Xpvda_VDDO_3 pvda $PINS VSSO=VSSO_CORE VSS=VSS_CORE VDDO=VDDO_CORE VDD=VDD_CORE
Xpv0a_VSSO_3 pv0a $PINS VSSO=VSSO_CORE VSS=VSS_CORE VDDO=VDDO_CORE VDD=VDD_CORE
.ENDS
