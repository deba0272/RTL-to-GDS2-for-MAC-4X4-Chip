//  library SCL-180 PDK Spectre Model File
simulator lang=spectre insensitive=yes

//section nom
include "ts18sl_scl.lib" section=ss_18
