************************************************************************
* Library Name: LogicCells
* Cell Name:    dff
* View Name:    schematic
************************************************************************

.SUBCKT dff D GND RST_N VDD clk out
*.PININFO RST_N:I clk:I D:B GND:B VDD:B out:B
MM7 net5 clk net4 GND N W=420e-3u L=0.18u m=1.0
MM5 net1 net2 net3 GND N W=420e-3u L=0.18u m=1.0
MM10 out net5 GND GND N W=0.6u L=0.18u m=1.0
MM8 net4 net1 GND GND N W=420e-3u L=0.18u m=1.0
MM6 net3 clk GND GND N W=420e-3u L=0.18u m=1.0
MM4 net2 D GND GND N W=420e-3u L=0.18u m=1.0
MM25 net1 RST_N GND GND N W=420e-3u L=0.18u m=1.0
MM3 net5 net1 VDD VDD P W=420e-3u L=0.18u m=1.0
MM2 net1 clk VDD VDD P W=420e-3u L=0.18u m=1.0
MM0 net6 D VDD VDD P W=420e-3u L=0.18u m=1.0
MM9 out net5 VDD VDD P W=0.6u L=0.18u m=1.0
MM1 net2 clk net6 VDD P W=420e-3u L=0.18u m=1.0
.ENDS

************************************************************************
* Library Name: LogicCells
* Cell Name:    inverter
* View Name:    schematic
************************************************************************

.SUBCKT inverter GND IN OUT VDD
*.PININFO IN:I OUT:O GND:B VDD:B
MM1 OUT IN GND GND N W=1.0u L=0.18u m=1.0
MM0 OUT IN VDD VDD P W=2.0u L=0.18u m=1.0
.ENDS

************************************************************************
* Library Name: LogicCells
* Cell Name:    nand2x1
* View Name:    schematic
************************************************************************

.SUBCKT nand2x1 A B GND VDD Y
*.PININFO A:I B:I Y:O GND:B VDD:B
MM1 net1 B GND GND N W=0.405u L=0.18u m=1.0
MM0 Y A net1 GND N W=0.405u L=0.18u m=1.0
MM3 Y B VDD VDD P W=0.36u L=0.18u m=1.0
MM2 Y A VDD VDD P W=0.36u L=0.18u m=1.0
.ENDS

************************************************************************
* Library Name: LogicCells
* Cell Name:    nor2
* View Name:    schematic
************************************************************************

.SUBCKT nor2 A B GND VDD Y
*.PININFO A:I B:I Y:O GND:B VDD:B
MM1 Y B GND GND N W=0.22u L=0.18u m=1.0
MM0 Y A GND GND N W=0.22u L=0.18u m=1.0
MM3 Y B net1 VDD P W=3.76u L=0.18u m=1.0
MM2 net1 A VDD VDD P W=3.76u L=0.18u m=1.0
.ENDS
