************************************************************************
* auCdl Netlist:
*
* Library Name:  LogicCells
* Top Cell Name: nand2x1
* View Name:     schematic
* Netlisted on:  Jun 24 15:40:31 2026
************************************************************************

.INCLUDE  /home/iep4/projects/user4/cds_master/SCLSL18_6M1L/ts018_scl_prim/cdlNetlist.header
*.EQUATION
*.SCALE METER
*.MEGA
.PARAM

************************************************************************
* Library Name: LogicCells
* Cell Name:    nand2x1
* View Name:    schematic
************************************************************************

.SUBCKT nand2x1 A B GND VDD Y
*.PININFO A:I B:I Y:O GND:B VDD:B
MM1 net1 B GND GND N W=0.405 L=0.18 m=1.0
MM0 Y A net1 GND N W=0.405 L=0.18 m=1.0
MM3 Y B VDD VDD P W=0.36 L=0.18 m=1.0
MM2 Y A VDD VDD P W=0.36 L=0.18 m=1.0
.ENDS
