techBindTechFile(ddGetObj("user4_iep4") "ts018_scl_prim" "tech.db" t)
techBindTechFile(ddGetObj("user4_master") "ts018_scl_prim" "tech.db" t)
