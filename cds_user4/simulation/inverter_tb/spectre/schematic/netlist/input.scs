// Generated for: spectre
// Generated on: Jun 24 11:24:54 2026
// Design library name: basic_gates
// Design cell name: inverter_tb
// Design view name: schematic
simulator lang=spectre
global 0 vdd!
include "/home/iep4/projects/user4/work_libs/iep4/cds/ts18sl_scl.lib" section=tt_18

// Library name: basic_gates
// Cell name: inverter
// View name: calibre
subckt inverter_calibre GND IN OUT VDD
    MM1 (MM1_d MM1_g MM1_s MM1_b) n18 w=1 l=0.18 as=0.48 ad=0.48 ps=2.96 \
        pd=2.96 m=1
    MM0 (MM0_d MM0_g MM0_s MM0_b) p18 w=2 l=0.18 as=0.96 ad=0.96 ps=4.96 \
        pd=4.96 m=1
    cc_40 (c_50_n c_80_n) capacitor c=8.75753e-18
    cc_39 (MM0_b c_67_n) capacitor c=2.44958e-16
    cc_38 (c_50_n c_67_n) capacitor c=2.0508e-17
    cc_37 (c_50_n OUT) capacitor c=2.45139e-17
    cc_36 (c_23_n c_76_n) capacitor c=9.14919e-18
    cc_35 (MM1_b c_68_n) capacitor c=4.64699e-18
    cc_34 (MM1_b c_67_n) capacitor c=1.26916e-17
    cc_33 (MM1_b c_65_n) capacitor c=6.54084e-17
    cc_32 (c_26_n c_65_n) capacitor c=7.49149e-17
    cc_31 (c_23_n c_65_n) capacitor c=2.35843e-17
    cc_30 (MM1_b OUT) capacitor c=1.42406e-16
    cc_29 (c_23_n OUT) capacitor c=3.75601e-17
    cc_28 (c_26_n MM0_b) capacitor c=3.24551e-17
    cc_27 (c_23_n MM0_b) capacitor c=2.45014e-18
    cc_26 (MM1_b c_51_n) capacitor c=2.15861e-16
    cc_25 (MM1_b c_50_n) capacitor c=2.78853e-16
    cc_24 (c_26_n c_50_n) capacitor c=2.1331e-18
    cc_23 (MM1_b c_49_n) capacitor c=9.65506e-18
    cc_22 (c_12_p c_68_n) capacitor c=1.75514e-17
    cc_21 (MM0_g c_67_n) capacitor c=6.57144e-17
    cc_20 (MM1_g c_65_n) capacitor c=4.15682e-17
    cc_19 (c_3_p c_65_n) capacitor c=5.45483e-18
    cc_18 (c_5_p MM0_b) capacitor c=2.6046e-17
    cc_17 (MM0_g MM0_b) capacitor c=1.94304e-16
    cc_16 (c_3_p c_51_n) capacitor c=4.08196e-18
    cc_15 (c_2_p c_51_n) capacitor c=1.11719e-17
    cc_14 (MM0_g c_50_n) capacitor c=6.39094e-18
    cc_13 (MM0_g c_49_n) capacitor c=3.55446e-19
    cc_12 (c_12_p MM1_b) capacitor c=8.8878e-18
    cc_11 (c_11_p MM1_b) capacitor c=8.45217e-17
    cc_10 (c_5_p MM1_b) capacitor c=1.76081e-16
    cc_9 (MM0_g MM1_b) capacitor c=1.7345e-17
    cc_8 (MM1_g MM1_b) capacitor c=1.12742e-16
    cc_7 (c_3_p MM1_b) capacitor c=1.97815e-17
    cc_6 (c_2_p MM1_b) capacitor c=6.92334e-17
    cc_5 (c_5_p c_26_n) capacitor c=3.12079e-17
    cc_4 (MM1_g c_26_n) capacitor c=2.41123e-17
    cc_3 (c_3_p c_24_n) capacitor c=7.24304e-18
    cc_2 (c_2_p c_24_n) capacitor c=1.70659e-17
    cc_1 (MM1_g c_23_n) capacitor c=6.91724e-18
    ciVDD_17 (c_49_n _net0) capacitor c=1.71047e-18
    ciVDD_16 (MM0_b _net0) capacitor c=7.36998e-17
    ciGND_27 (GND_5 _net0) capacitor c=1.71047e-18
    ciGND_26 (c_26_n _net0) capacitor c=3.53329e-17
    ciIN_22 (c_11_p _net0) capacitor c=3.1719e-18
    rOUT_28 (OUT OUT_12) resistor r=0.606957
    rOUT_27 (OUT_2 c_65_n) resistor r=0.352857
    rOUT_26 (OUT_2 c_68_n) resistor r=0.0286749
    rOUT_25 (c_65_n c_76_n) resistor r=5
    rOUT_24 (OUT_6 c_67_n) resistor r=0.384286
    rOUT_23 (OUT_6 c_68_n) resistor r=0.0286749
    rOUT_22 (c_67_n OUT_10) resistor r=0.3
    rOUT_21 (c_67_n c_80_n) resistor r=3.33333
    rOUT_20 (OUT_10 OUT_28) resistor r=10
    rOUT_19 (OUT_12 c_68_n) resistor r=0.0135055
    rOUT_18 (c_76_n MM1_d) resistor r=0.21
    rOUT_17 (c_80_n MM0_d) resistor r=3.79167
    rOUT_16 (OUT_28 MM0_d) resistor r=11.5208
    rVDD_28 (VDD c_50_n) resistor r=0.192
    rVDD_27 (VDD_4 MM0_b) resistor r=0.0475695
    rVDD_26 (VDD_4 MM0_b) resistor r=0.0277668
    rVDD_25 (c_49_n VDD_16) resistor r=0.21913
    rVDD_24 (c_49_n c_51_n) resistor r=0.00880368
    rVDD_23 (c_50_n c_51_n) resistor r=0.0338756
    rVDD_22 (VDD_16 MM0_b) resistor r=0.0736429
    rVDD_21 (MM0_b VDD_33) resistor r=3.33333
    rVDD_20 (MM0_b VDD_38) resistor r=10
    rVDD_19 (VDD_33 MM0_s) resistor r=3.79167
    rVDD_18 (VDD_38 MM0_s) resistor r=11.5208
    rGND_35 (GND c_23_n) resistor r=0.192
    rGND_34 (GND_4 GND_5) resistor r=0.186087
    rGND_33 (GND_4 c_24_n) resistor r=0.00880368
    rGND_32 (GND_5 MM1_b) resistor r=0.0598751
    rGND_31 (c_23_n c_24_n) resistor r=0.0338756
    rGND_30 (c_26_n MM1_b) resistor r=0.0747826
    rGND_29 (c_26_n GND_26) resistor r=5
    rGND_28 (GND_26 MM1_s) resistor r=0.21
    rIN_32 (IN c_2_p) resistor r=0.257391
    rIN_31 (c_2_p c_3_p) resistor r=0.0484152
    rIN_30 (c_3_p IN_21) resistor r=7
    rIN_29 (MM1_g IN_12) resistor r=32.6667
    rIN_28 (MM0_g IN_16) resistor r=54
    rIN_27 (c_5_p c_11_p) resistor r=71.3333
    rIN_26 (c_5_p c_12_p) resistor r=0.660276
    rIN_25 (c_11_p IN_21) resistor r=4.9993
    rIN_24 (IN_12 c_12_p) resistor r=2.54067
    rIN_23 (IN_16 c_12_p) resistor r=2.54067
ends inverter_calibre
// End of subcircuit definition.

// Library name: basic_gates
// Cell name: inverter_tb
// View name: schematic
I0 (0 IN OUT vdd!) inverter_calibre
V0 (vdd! 0) vsource dc=1.8 type=dc
V1 (IN 0) vsource type=pulse val0=0 val1=1.8 period=10n delay=2.5n rise=1p \
        fall=1p width=5n
simulatorOptions options psfversion="1.4.0" reltol=1e-3 vabstol=1e-6 \
    iabstol=1e-12 temp=27 tnom=27 scalem=1.0 scale=1e-06 gmin=1e-12 \
    rforce=1 maxnotes=5 maxwarns=5 digits=5 cols=80 pivrel=1e-3 \
    sensfile="../psf/sens.output" checklimitdest=both
tran tran stop=200n errpreset=moderate write="spectre.ic" \
    writefinal="spectre.fc" annotate=status maxiters=5
finalTimeOP info what=oppoint where=rawfile
modelParameter info what=models where=rawfile
element info what=inst where=rawfile
outputParameter info what=output where=rawfile
designParamVals info what=parameters where=rawfile
primitives info what=primitives where=rawfile
subckts info what=subckts where=rawfile
saveOptions options save=allpub subcktprobelvl=2
